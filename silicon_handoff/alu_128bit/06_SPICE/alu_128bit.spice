* SPICE — alu_128bit | 1321 cells

.subckt AND2 A B Y
B_AND internal 0 V=0.5*(tanh(20*(V(A)-0.5))+1)*(tanh(20*(V(B)-0.5))+1)
R_out internal Y 1
R_pull Y 0 100k
C_load Y 0 10f
.ends

.subckt ANDN2 A B Y
B_ANDN internal 0 V=0.5*(tanh(20*(V(A)-0.5))+1)*(1-0.5*(tanh(20*(V(B)-0.5))+1))
R_out internal Y 1
R_pull Y 0 100k
C_load Y 0 10f
.ends

.subckt CELL_carry_lo A B Y
B_CELL_carry_lo internal 0 V=0.5*(tanh(20*(V(A)-0.5))+1)*(tanh(20*(V(B)-0.5))+1)
R_out internal Y 1
R_pull Y 0 100k
C_load Y 0 10f
.ends

.subckt NAND2 A B Y
B_NAND internal 0 V=1-0.5*(tanh(20*(V(A)-0.5))+1)*(tanh(20*(V(B)-0.5))+1)
R_out internal Y 1
R_pull Y 0 100k
C_load Y 0 10f
.ends

.subckt NOR2 A B Y
B_NOR internal 0 V=1-(0.5*(tanh(20*(V(A)-0.5))+tanh(20*(V(B)-0.5))+2) - 0.5*(tanh(20*(V(A)-0.5))+1)*(tanh(20*(V(B)-0.5))+1))
R_out internal Y 1
R_pull Y 0 100k
C_load Y 0 10f
.ends

.subckt OR2 A B Y
B_OR internal 0 V=0.5*(tanh(20*(V(A)-0.5))+tanh(20*(V(B)-0.5))+2) - 0.5*(tanh(20*(V(A)-0.5))+1)*(tanh(20*(V(B)-0.5))+1)
R_out internal Y 1
R_pull Y 0 100k
C_load Y 0 10f
.ends

.subckt ORN2 A B Y
B_ORN internal 0 V=0.5*(tanh(20*(V(A)-0.5))+tanh(20*(V(B)-0.5))+2) - V(A)*0.5*(tanh(20*(V(B)-0.5))+1)
R_out internal Y 1
R_pull Y 0 100k
C_load Y 0 10f
.ends

.subckt XNOR2 A B Y
B_XNOR internal 0 V=1-0.5*(tanh(20*(V(A)-0.5))-tanh(20*(V(B)-0.5)))**2
R_out internal Y 1
R_pull Y 0 100k
C_load Y 0 10f
.ends

* MAIN: alu_128bit

X0 a b w393 OR2
X1 op op w394 ANDN2
X2 op w394 w395 NAND2
X3 a b w396 NAND2
X4 op op w397 NOR2
X5 op w397 w398 AND2
X6 w396 w398 w399 NAND2
X7 w395 w399 w400 NAND2
X8 w393 w400 w401 NAND2
X9 w394 op w402 ANDN2
X10 w396 w402 w403 ORN2
X11 op op w404 ORN2
X12 op w404 w405 OR2
X13 op op w406 NOR2
X14 w407 w406 w408 NAND2
X15 w403 w408 w409 AND2
X16 w401 w409 result NAND2
X17 a b w410 OR2
X18 a b w411 AND2
X19 w411 w398 w412 ORN2
X20 w395 w412 w413 NAND2
X21 w410 w413 w414 NAND2
X22 w415 w406 w416 NAND2
X23 w402 w411 w417 NAND2
X24 w416 w417 w418 AND2
X25 w414 w418 result NAND2
X26 a b w419 OR2
X27 a b w420 AND2
X28 w420 w398 w421 ORN2
X29 w395 w421 w422 NAND2
X30 w419 w422 w423 NAND2
X31 w424 w406 w425 NAND2
X32 w402 w420 w426 NAND2
X33 w425 w426 w427 AND2
X34 w423 w427 result NAND2
X35 a b w428 OR2
X36 a b w429 AND2
X37 w429 w398 w430 ORN2
X38 w395 w430 w431 NAND2
X39 w428 w431 w432 NAND2
X40 w433 w406 w434 NAND2
X41 w402 w429 w435 NAND2
X42 w434 w435 w436 AND2
X43 w432 w436 result NAND2
X44 a b w437 OR2
X45 a b w438 AND2
X46 w438 w398 w439 ORN2
X47 w395 w439 w440 NAND2
X48 w437 w440 w441 NAND2
X49 w402 w438 w442 NAND2
X50 w443 w406 w444 NAND2
X51 w442 w444 w445 AND2
X52 w441 w445 result NAND2
X53 a b w446 OR2
X54 a b w447 AND2
X55 w447 w398 w448 ORN2
X56 w395 w448 w449 NAND2
X57 w446 w449 w450 NAND2
X58 w451 w406 w452 NAND2
X59 w402 w447 w453 NAND2
X60 w452 w453 w454 AND2
X61 w450 w454 result NAND2
X62 a b w455 OR2
X63 a b w456 AND2
X64 w456 w398 w457 ORN2
X65 w395 w457 w458 NAND2
X66 w455 w458 w459 NAND2
X67 w460 w406 w461 NAND2
X68 w402 w456 w462 NAND2
X69 w461 w462 w463 AND2
X70 w459 w463 result NAND2
X71 a b w464 OR2
X72 a b w465 AND2
X73 w465 w398 w466 ORN2
X74 w395 w466 w467 NAND2
X75 w464 w467 w468 NAND2
X76 w402 w465 w469 NAND2
X77 w470 w406 w471 NAND2
X78 w469 w471 w472 AND2
X79 w468 w472 result NAND2
X80 a b w473 OR2
X81 a b w474 AND2
X82 w474 w398 w475 ORN2
X83 w395 w475 w476 NAND2
X84 w473 w476 w477 NAND2
X85 w402 w474 w478 NAND2
X86 w479 w406 w480 NAND2
X87 w478 w480 w481 AND2
X88 w477 w481 result NAND2
X89 a b w482 OR2
X90 a b w483 AND2
X91 w483 w398 w484 ORN2
X92 w395 w484 w485 NAND2
X93 w482 w485 w486 NAND2
X94 w487 w406 w488 NAND2
X95 w402 w483 w489 NAND2
X96 w488 w489 w490 AND2
X97 w486 w490 result NAND2
X98 a b w491 OR2
X99 a b w492 AND2
X100 w492 w398 w493 ORN2
X101 w395 w493 w494 NAND2
X102 w491 w494 w495 NAND2
X103 w496 w406 w497 NAND2
X104 w402 w492 w498 NAND2
X105 w497 w498 w499 AND2
X106 w495 w499 result NAND2
X107 a b w500 OR2
X108 a b w501 AND2
X109 w501 w398 w502 ORN2
X110 w395 w502 w503 NAND2
X111 w500 w503 w504 NAND2
X112 w402 w501 w505 NAND2
X113 w506 w406 w507 NAND2
X114 w505 w507 w508 AND2
X115 w504 w508 result NAND2
X116 a b w509 OR2
X117 a b w510 AND2
X118 w510 w398 w511 ORN2
X119 w395 w511 w512 NAND2
X120 w509 w512 w513 NAND2
X121 w402 w510 w514 NAND2
X122 w515 w406 w516 NAND2
X123 w514 w516 w517 AND2
X124 w513 w517 result NAND2
X125 a b w518 OR2
X126 a b w519 AND2
X127 w519 w398 w520 ORN2
X128 w395 w520 w521 NAND2
X129 w518 w521 w522 NAND2
X130 w402 w519 w523 NAND2
X131 w524 w406 w525 NAND2
X132 w523 w525 w526 AND2
X133 w522 w526 result NAND2
X134 a b w527 OR2
X135 a b w528 AND2
X136 w528 w398 w529 ORN2
X137 w395 w529 w530 NAND2
X138 w527 w530 w531 NAND2
X139 w532 w406 w533 NAND2
X140 w402 w528 w534 NAND2
X141 w533 w534 w535 AND2
X142 w531 w535 result NAND2
X143 a b w536 OR2
X144 a b w537 AND2
X145 w537 w398 w538 ORN2
X146 w395 w538 w539 NAND2
X147 w536 w539 w540 NAND2
X148 w541 w406 w542 NAND2
X149 w402 w537 w543 NAND2
X150 w542 w543 w544 AND2
X151 w540 w544 result NAND2
X152 a b w545 OR2
X153 a b w546 AND2
X154 w546 w398 w547 ORN2
X155 w395 w547 w548 NAND2
X156 w545 w548 w549 NAND2
X157 w402 w546 w550 NAND2
X158 w551 w406 w552 NAND2
X159 w550 w552 w553 AND2
X160 w549 w553 result NAND2
X161 a b w554 OR2
X162 a b w555 AND2
X163 w555 w398 w556 ORN2
X164 w395 w556 w557 NAND2
X165 w554 w557 w558 NAND2
X166 w559 w406 w560 NAND2
X167 w402 w555 w561 NAND2
X168 w560 w561 w562 AND2
X169 w558 w562 result NAND2
X170 a b w563 OR2
X171 a b w564 AND2
X172 w564 w398 w565 ORN2
X173 w395 w565 w566 NAND2
X174 w563 w566 w567 NAND2
X175 w568 w406 w569 NAND2
X176 w402 w564 w570 NAND2
X177 w569 w570 w571 AND2
X178 w567 w571 result NAND2
X179 a b w572 OR2
X180 a b w573 AND2
X181 w573 w398 w574 ORN2
X182 w395 w574 w575 NAND2
X183 w572 w575 w576 NAND2
X184 w577 w406 w578 NAND2
X185 w402 w573 w579 NAND2
X186 w578 w579 w580 AND2
X187 w576 w580 result NAND2
X188 a b w581 OR2
X189 a b w582 AND2
X190 w582 w398 w583 ORN2
X191 w395 w583 w584 NAND2
X192 w581 w584 w585 NAND2
X193 w402 w582 w586 NAND2
X194 w587 w406 w588 NAND2
X195 w586 w588 w589 AND2
X196 w585 w589 result NAND2
X197 a b w590 OR2
X198 a b w591 AND2
X199 w591 w398 w592 ORN2
X200 w395 w592 w593 NAND2
X201 w590 w593 w594 NAND2
X202 w595 w406 w596 NAND2
X203 w402 w591 w597 NAND2
X204 w596 w597 w598 AND2
X205 w594 w598 result NAND2
X206 a b w599 OR2
X207 a b w600 AND2
X208 w600 w398 w601 ORN2
X209 w395 w601 w602 NAND2
X210 w599 w602 w603 NAND2
X211 w604 w406 w605 NAND2
X212 w402 w600 w606 NAND2
X213 w605 w606 w607 AND2
X214 w603 w607 result NAND2
X215 a b w608 OR2
X216 a b w609 AND2
X217 w609 w398 w610 ORN2
X218 w395 w610 w611 NAND2
X219 w608 w611 w612 NAND2
X220 w402 w609 w613 NAND2
X221 w614 w406 w615 NAND2
X222 w613 w615 w616 AND2
X223 w612 w616 result NAND2
X224 a b w617 OR2
X225 a b w618 AND2
X226 w618 w398 w619 ORN2
X227 w395 w619 w620 NAND2
X228 w617 w620 w621 NAND2
X229 w402 w618 w622 NAND2
X230 w623 w406 w624 NAND2
X231 w622 w624 w625 AND2
X232 w621 w625 result NAND2
X233 a b w626 OR2
X234 a b w627 AND2
X235 w627 w398 w628 ORN2
X236 w395 w628 w629 NAND2
X237 w626 w629 w630 NAND2
X238 w631 w406 w632 NAND2
X239 w402 w627 w633 NAND2
X240 w632 w633 w634 AND2
X241 w630 w634 result NAND2
X242 a b w635 OR2
X243 a b w636 AND2
X244 w636 w398 w637 ORN2
X245 w395 w637 w638 NAND2
X246 w635 w638 w639 NAND2
X247 w640 w406 w641 NAND2
X248 w402 w636 w642 NAND2
X249 w641 w642 w643 AND2
X250 w639 w643 result NAND2
X251 a b w644 OR2
X252 a b w645 AND2
X253 w645 w398 w646 ORN2
X254 w395 w646 w647 NAND2
X255 w644 w647 w648 NAND2
X256 w402 w645 w649 NAND2
X257 w650 w406 w651 NAND2
X258 w649 w651 w652 AND2
X259 w648 w652 result NAND2
X260 a b w653 OR2
X261 a b w654 AND2
X262 w654 w398 w655 ORN2
X263 w395 w655 w656 NAND2
X264 w653 w656 w657 NAND2
X265 w402 w654 w658 NAND2
X266 w659 w406 w660 NAND2
X267 w658 w660 w661 AND2
X268 w657 w661 result NAND2
X269 a b w662 OR2
X270 a b w663 AND2
X271 w663 w398 w664 ORN2
X272 w395 w664 w665 NAND2
X273 w662 w665 w666 NAND2
X274 w402 w663 w667 NAND2
X275 w668 w406 w669 NAND2
X276 w667 w669 w670 AND2
X277 w666 w670 result NAND2
X278 a b w671 OR2
X279 a b w672 AND2
X280 w672 w398 w673 ORN2
X281 w395 w673 w674 NAND2
X282 w671 w674 w675 NAND2
X283 w676 w406 w677 NAND2
X284 w402 w672 w678 NAND2
X285 w677 w678 w679 AND2
X286 w675 w679 result NAND2
X287 a b w680 OR2
X288 a b w681 AND2
X289 w681 w398 w682 ORN2
X290 w395 w682 w683 NAND2
X291 w680 w683 w684 NAND2
X292 w685 w406 w686 NAND2
X293 w402 w681 w687 NAND2
X294 w686 w687 w688 AND2
X295 w684 w688 result NAND2
X296 a b w689 OR2
X297 a b w690 AND2
X298 w690 w398 w691 ORN2
X299 w395 w691 w692 NAND2
X300 w689 w692 w693 NAND2
X301 w694 w406 w695 NAND2
X302 w402 w690 w696 NAND2
X303 w695 w696 w697 AND2
X304 w693 w697 result NAND2
X305 a b w698 OR2
X306 a b w699 AND2
X307 w699 w398 w700 ORN2
X308 w395 w700 w701 NAND2
X309 w698 w701 w702 NAND2
X310 w703 w406 w704 NAND2
X311 w402 w699 w705 NAND2
X312 w704 w705 w706 AND2
X313 w702 w706 result NAND2
X314 a b w707 OR2
X315 a b w708 AND2
X316 w708 w398 w709 ORN2
X317 w395 w709 w710 NAND2
X318 w707 w710 w711 NAND2
X319 w712 w406 w713 NAND2
X320 w402 w708 w714 NAND2
X321 w713 w714 w715 AND2
X322 w711 w715 result NAND2
X323 a b w716 OR2
X324 a b w717 AND2
X325 w717 w398 w718 ORN2
X326 w395 w718 w719 NAND2
X327 w716 w719 w720 NAND2
X328 w721 w406 w722 NAND2
X329 w402 w717 w723 NAND2
X330 w722 w723 w724 AND2
X331 w720 w724 result NAND2
X332 a b w725 OR2
X333 a b w726 AND2
X334 w726 w398 w727 ORN2
X335 w395 w727 w728 NAND2
X336 w725 w728 w729 NAND2
X337 w402 w726 w730 NAND2
X338 w731 w406 w732 NAND2
X339 w730 w732 w733 AND2
X340 w729 w733 result NAND2
X341 a b w734 OR2
X342 a b w735 AND2
X343 w735 w398 w736 ORN2
X344 w395 w736 w737 NAND2
X345 w734 w737 w738 NAND2
X346 w739 w406 w740 NAND2
X347 w402 w735 w741 NAND2
X348 w740 w741 w742 AND2
X349 w738 w742 result NAND2
X350 a b w743 OR2
X351 a b w744 AND2
X352 w744 w398 w745 ORN2
X353 w395 w745 w746 NAND2
X354 w743 w746 w747 NAND2
X355 w748 w406 w749 NAND2
X356 w402 w744 w750 NAND2
X357 w749 w750 w751 AND2
X358 w747 w751 result NAND2
X359 a b w752 OR2
X360 a b w753 AND2
X361 w753 w398 w754 ORN2
X362 w395 w754 w755 NAND2
X363 w752 w755 w756 NAND2
X364 w402 w753 w757 NAND2
X365 w758 w406 w759 NAND2
X366 w757 w759 w760 AND2
X367 w756 w760 result NAND2
X368 a b w761 OR2
X369 a b w762 AND2
X370 w762 w398 w763 ORN2
X371 w395 w763 w764 NAND2
X372 w761 w764 w765 NAND2
X373 w402 w762 w766 NAND2
X374 w767 w406 w768 NAND2
X375 w766 w768 w769 AND2
X376 w765 w769 result NAND2
X377 a b w770 OR2
X378 a b w771 AND2
X379 w771 w398 w772 ORN2
X380 w395 w772 w773 NAND2
X381 w770 w773 w774 NAND2
X382 w775 w406 w776 NAND2
X383 w402 w771 w777 NAND2
X384 w776 w777 w778 AND2
X385 w774 w778 result NAND2
X386 a b w779 OR2
X387 a b w780 AND2
X388 w780 w398 w781 ORN2
X389 w395 w781 w782 NAND2
X390 w779 w782 w783 NAND2
X391 w784 w406 w785 NAND2
X392 w402 w780 w786 NAND2
X393 w785 w786 w787 AND2
X394 w783 w787 result NAND2
X395 a b w788 OR2
X396 a b w789 AND2
X397 w789 w398 w790 ORN2
X398 w395 w790 w791 NAND2
X399 w788 w791 w792 NAND2
X400 w402 w789 w793 NAND2
X401 w794 w406 w795 NAND2
X402 w793 w795 w796 AND2
X403 w792 w796 result NAND2
X404 a b w797 OR2
X405 a b w798 AND2
X406 w798 w398 w799 ORN2
X407 w395 w799 w800 NAND2
X408 w797 w800 w801 NAND2
X409 w402 w798 w802 NAND2
X410 w803 w406 w804 NAND2
X411 w802 w804 w805 AND2
X412 w801 w805 result NAND2
X413 a b w806 OR2
X414 a b w807 AND2
X415 w807 w398 w808 ORN2
X416 w395 w808 w809 NAND2
X417 w806 w809 w810 NAND2
X418 w402 w807 w811 NAND2
X419 w812 w406 w813 NAND2
X420 w811 w813 w814 AND2
X421 w810 w814 result NAND2
X422 a b w815 OR2
X423 a b w816 AND2
X424 w816 w398 w817 ORN2
X425 w395 w817 w818 NAND2
X426 w815 w818 w819 NAND2
X427 w820 w406 w821 NAND2
X428 w402 w816 w822 NAND2
X429 w821 w822 w823 AND2
X430 w819 w823 result NAND2
X431 a b w824 OR2
X432 a b w825 AND2
X433 w825 w398 w826 ORN2
X434 w395 w826 w827 NAND2
X435 w824 w827 w828 NAND2
X436 w829 w406 w830 NAND2
X437 w402 w825 w831 NAND2
X438 w830 w831 w832 AND2
X439 w828 w832 result NAND2
X440 a b w833 OR2
X441 a b w834 AND2
X442 w834 w398 w835 ORN2
X443 w395 w835 w836 NAND2
X444 w833 w836 w837 NAND2
X445 w402 w834 w838 NAND2
X446 w839 w406 w840 NAND2
X447 w838 w840 w841 AND2
X448 w837 w841 result NAND2
X449 a b w842 OR2
X450 a b w843 AND2
X451 w843 w398 w844 ORN2
X452 w395 w844 w845 NAND2
X453 w842 w845 w846 NAND2
X454 w847 w406 w848 NAND2
X455 w402 w843 w849 NAND2
X456 w848 w849 w850 AND2
X457 w846 w850 result NAND2
X458 a b w851 OR2
X459 a b w852 AND2
X460 w852 w398 w853 ORN2
X461 w395 w853 w854 NAND2
X462 w851 w854 w855 NAND2
X463 w856 w406 w857 NAND2
X464 w402 w852 w858 NAND2
X465 w857 w858 w859 AND2
X466 w855 w859 result NAND2
X467 a b w860 OR2
X468 a b w861 AND2
X469 w861 w398 w862 ORN2
X470 w395 w862 w863 NAND2
X471 w860 w863 w864 NAND2
X472 w865 w406 w866 NAND2
X473 w402 w861 w867 NAND2
X474 w866 w867 w868 AND2
X475 w864 w868 result NAND2
X476 a b w869 OR2
X477 a b w870 AND2
X478 w870 w398 w871 ORN2
X479 w395 w871 w872 NAND2
X480 w869 w872 w873 NAND2
X481 w402 w870 w874 NAND2
X482 w875 w406 w876 NAND2
X483 w874 w876 w877 AND2
X484 w873 w877 result NAND2
X485 a b w878 OR2
X486 a b w879 AND2
X487 w879 w398 w880 ORN2
X488 w395 w880 w881 NAND2
X489 w878 w881 w882 NAND2
X490 w883 w406 w884 NAND2
X491 w402 w879 w885 NAND2
X492 w884 w885 w886 AND2
X493 w882 w886 result NAND2
X494 a b w887 OR2
X495 a b w888 AND2
X496 w888 w398 w889 ORN2
X497 w395 w889 w890 NAND2
X498 w887 w890 w891 NAND2
X499 w892 w406 w893 NAND2
X500 w402 w888 w894 NAND2
X501 w893 w894 w895 AND2
X502 w891 w895 result NAND2
X503 a b w896 OR2
X504 a b w897 AND2
X505 w897 w398 w898 ORN2
X506 w395 w898 w899 NAND2
X507 w896 w899 w900 NAND2
X508 w402 w897 w901 NAND2
X509 w902 w406 w903 NAND2
X510 w901 w903 w904 AND2
X511 w900 w904 result NAND2
X512 a b w905 OR2
X513 a b w906 AND2
X514 w906 w398 w907 ORN2
X515 w395 w907 w908 NAND2
X516 w905 w908 w909 NAND2
X517 w402 w906 w910 NAND2
X518 w911 w406 w912 NAND2
X519 w910 w912 w913 AND2
X520 w909 w913 result NAND2
X521 a b w914 OR2
X522 a b w915 AND2
X523 w915 w398 w916 ORN2
X524 w395 w916 w917 NAND2
X525 w914 w917 w918 NAND2
X526 w919 w406 w920 NAND2
X527 w402 w915 w921 NAND2
X528 w920 w921 w922 AND2
X529 w918 w922 result NAND2
X530 a b w923 OR2
X531 a b w924 AND2
X532 w924 w398 w925 ORN2
X533 w395 w925 w926 NAND2
X534 w923 w926 w927 NAND2
X535 w928 w406 w929 NAND2
X536 w402 w924 w930 NAND2
X537 w929 w930 w931 AND2
X538 w927 w931 result NAND2
X539 a b w932 OR2
X540 a b w933 AND2
X541 w933 w398 w934 ORN2
X542 w395 w934 w935 NAND2
X543 w932 w935 w936 NAND2
X544 w402 w933 w937 NAND2
X545 w938 w406 w939 NAND2
X546 w937 w939 w940 AND2
X547 w936 w940 result NAND2
X548 a b w941 OR2
X549 a b w942 AND2
X550 w942 w398 w943 ORN2
X551 w395 w943 w944 NAND2
X552 w941 w944 w945 NAND2
X553 w402 w942 w946 NAND2
X554 w947 w406 w948 NAND2
X555 w946 w948 w949 AND2
X556 w945 w949 result NAND2
X557 a b w950 OR2
X558 a b w951 AND2
X559 w951 w398 w952 ORN2
X560 w395 w952 w953 NAND2
X561 w950 w953 w954 NAND2
X562 w402 w951 w955 NAND2
X563 w956 w406 w957 NAND2
X564 w955 w957 w958 AND2
X565 w954 w958 result NAND2
X566 a b w959 OR2
X567 a b w960 AND2
X568 w960 w398 w961 ORN2
X569 w395 w961 w962 NAND2
X570 w959 w962 w963 NAND2
X571 w964 w406 w965 NAND2
X572 w402 w960 w966 NAND2
X573 w965 w966 w967 AND2
X574 w963 w967 result NAND2
X575 a b w968 OR2
X576 a b w969 AND2
X577 w969 w398 w970 ORN2
X578 w395 w970 w971 NAND2
X579 w968 w971 w972 NAND2
X580 w973 w406 w974 NAND2
X581 w402 w969 w975 NAND2
X582 w974 w975 w976 AND2
X583 w972 w976 result NAND2
X584 a b w977 OR2
X585 a b w978 AND2
X586 w978 w398 w979 ORN2
X587 w395 w979 w980 NAND2
X588 w977 w980 w981 NAND2
X589 w982 w406 w983 NAND2
X590 w402 w978 w984 NAND2
X591 w983 w984 w985 AND2
X592 w981 w985 result NAND2
X593 a b w986 OR2
X594 a b w987 AND2
X595 w987 w398 w988 ORN2
X596 w395 w988 w989 NAND2
X597 w986 w989 w990 NAND2
X598 w991 w406 w992 NAND2
X599 w402 w987 w993 NAND2
X600 w992 w993 w994 AND2
X601 w990 w994 result NAND2
X602 a b w995 OR2
X603 a b w996 AND2
X604 w996 w398 w997 ORN2
X605 w395 w997 w998 NAND2
X606 w995 w998 w999 NAND2
X607 w1000 w406 w1001 NAND2
X608 w402 w996 w1002 NAND2
X609 w1001 w1002 w1003 AND2
X610 w999 w1003 result NAND2
X611 a b w1004 OR2
X612 a b w1005 AND2
X613 w1005 w398 w1006 ORN2
X614 w395 w1006 w1007 NAND2
X615 w1004 w1007 w1008 NAND2
X616 w1009 w406 w1010 NAND2
X617 w402 w1005 w1011 NAND2
X618 w1010 w1011 w1012 AND2
X619 w1008 w1012 result NAND2
X620 a b w1013 OR2
X621 a b w1014 AND2
X622 w1014 w398 w1015 ORN2
X623 w395 w1015 w1016 NAND2
X624 w1013 w1016 w1017 NAND2
X625 w402 w1014 w1018 NAND2
X626 w1019 w406 w1020 NAND2
X627 w1018 w1020 w1021 AND2
X628 w1017 w1021 result NAND2
X629 a b w1022 OR2
X630 a b w1023 AND2
X631 w1023 w398 w1024 ORN2
X632 w395 w1024 w1025 NAND2
X633 w1022 w1025 w1026 NAND2
X634 w1027 w406 w1028 NAND2
X635 w402 w1023 w1029 NAND2
X636 w1028 w1029 w1030 AND2
X637 w1026 w1030 result NAND2
X638 a b w1031 OR2
X639 a b w1032 AND2
X640 w1032 w398 w1033 ORN2
X641 w395 w1033 w1034 NAND2
X642 w1031 w1034 w1035 NAND2
X643 w1036 w406 w1037 NAND2
X644 w402 w1032 w1038 NAND2
X645 w1037 w1038 w1039 AND2
X646 w1035 w1039 result NAND2
X647 a b w1040 OR2
X648 a b w1041 AND2
X649 w1041 w398 w1042 ORN2
X650 w395 w1042 w1043 NAND2
X651 w1040 w1043 w1044 NAND2
X652 w402 w1041 w1045 NAND2
X653 w1046 w406 w1047 NAND2
X654 w1045 w1047 w1048 AND2
X655 w1044 w1048 result NAND2
X656 a b w1049 OR2
X657 a b w1050 AND2
X658 w1050 w398 w1051 ORN2
X659 w395 w1051 w1052 NAND2
X660 w1049 w1052 w1053 NAND2
X661 w402 w1050 w1054 NAND2
X662 w1055 w406 w1056 NAND2
X663 w1054 w1056 w1057 AND2
X664 w1053 w1057 result NAND2
X665 a b w1058 OR2
X666 a b w1059 AND2
X667 w1059 w398 w1060 ORN2
X668 w395 w1060 w1061 NAND2
X669 w1058 w1061 w1062 NAND2
X670 w1063 w406 w1064 NAND2
X671 w402 w1059 w1065 NAND2
X672 w1064 w1065 w1066 AND2
X673 w1062 w1066 result NAND2
X674 a b w1067 OR2
X675 a b w1068 AND2
X676 w1068 w398 w1069 ORN2
X677 w395 w1069 w1070 NAND2
X678 w1067 w1070 w1071 NAND2
X679 w1072 w406 w1073 NAND2
X680 w402 w1068 w1074 NAND2
X681 w1073 w1074 w1075 AND2
X682 w1071 w1075 result NAND2
X683 a b w1076 OR2
X684 a b w1077 AND2
X685 w1077 w398 w1078 ORN2
X686 w395 w1078 w1079 NAND2
X687 w1076 w1079 w1080 NAND2
X688 w402 w1077 w1081 NAND2
X689 w1082 w406 w1083 NAND2
X690 w1081 w1083 w1084 AND2
X691 w1080 w1084 result NAND2
X692 a b w1085 OR2
X693 a b w1086 AND2
X694 w1086 w398 w1087 ORN2
X695 w395 w1087 w1088 NAND2
X696 w1085 w1088 w1089 NAND2
X697 w402 w1086 w1090 NAND2
X698 w1091 w406 w1092 NAND2
X699 w1090 w1092 w1093 AND2
X700 w1089 w1093 result NAND2
X701 a b w1094 OR2
X702 a b w1095 AND2
X703 w1095 w398 w1096 ORN2
X704 w395 w1096 w1097 NAND2
X705 w1094 w1097 w1098 NAND2
X706 w402 w1095 w1099 NAND2
X707 w1100 w406 w1101 NAND2
X708 w1099 w1101 w1102 AND2
X709 w1098 w1102 result NAND2
X710 a b w1103 OR2
X711 a b w1104 AND2
X712 w1104 w398 w1105 ORN2
X713 w395 w1105 w1106 NAND2
X714 w1103 w1106 w1107 NAND2
X715 w1108 w406 w1109 NAND2
X716 w402 w1104 w1110 NAND2
X717 w1109 w1110 w1111 AND2
X718 w1107 w1111 result NAND2
X719 a b w1112 OR2
X720 a b w1113 AND2
X721 w1113 w398 w1114 ORN2
X722 w395 w1114 w1115 NAND2
X723 w1112 w1115 w1116 NAND2
X724 w1117 w406 w1118 NAND2
X725 w402 w1113 w1119 NAND2
X726 w1118 w1119 w1120 AND2
X727 w1116 w1120 result NAND2
X728 a b w1121 OR2
X729 a b w1122 AND2
X730 w1122 w398 w1123 ORN2
X731 w395 w1123 w1124 NAND2
X732 w1121 w1124 w1125 NAND2
X733 w402 w1122 w1126 NAND2
X734 w1127 w406 w1128 NAND2
X735 w1126 w1128 w1129 AND2
X736 w1125 w1129 result NAND2
X737 a b w1130 OR2
X738 a b w1131 AND2
X739 w1131 w398 w1132 ORN2
X740 w395 w1132 w1133 NAND2
X741 w1130 w1133 w1134 NAND2
X742 w1135 w406 w1136 NAND2
X743 w402 w1131 w1137 NAND2
X744 w1136 w1137 w1138 AND2
X745 w1134 w1138 result NAND2
X746 a b w1139 OR2
X747 a b w1140 AND2
X748 w1140 w398 w1141 ORN2
X749 w395 w1141 w1142 NAND2
X750 w1139 w1142 w1143 NAND2
X751 w1144 w406 w1145 NAND2
X752 w402 w1140 w1146 NAND2
X753 w1145 w1146 w1147 AND2
X754 w1143 w1147 result NAND2
X755 a b w1148 OR2
X756 a b w1149 AND2
X757 w1149 w398 w1150 ORN2
X758 w395 w1150 w1151 NAND2
X759 w1148 w1151 w1152 NAND2
X760 w1153 w406 w1154 NAND2
X761 w402 w1149 w1155 NAND2
X762 w1154 w1155 w1156 AND2
X763 w1152 w1156 result NAND2
X764 a b w1157 OR2
X765 a b w1158 AND2
X766 w1158 w398 w1159 ORN2
X767 w395 w1159 w1160 NAND2
X768 w1157 w1160 w1161 NAND2
X769 w402 w1158 w1162 NAND2
X770 w1163 w406 w1164 NAND2
X771 w1162 w1164 w1165 AND2
X772 w1161 w1165 result NAND2
X773 a b w1166 OR2
X774 a b w1167 AND2
X775 w1167 w398 w1168 ORN2
X776 w395 w1168 w1169 NAND2
X777 w1166 w1169 w1170 NAND2
X778 w1171 w406 w1172 NAND2
X779 w402 w1167 w1173 NAND2
X780 w1172 w1173 w1174 AND2
X781 w1170 w1174 result NAND2
X782 a b w1175 OR2
X783 a b w1176 AND2
X784 w1176 w398 w1177 ORN2
X785 w395 w1177 w1178 NAND2
X786 w1175 w1178 w1179 NAND2
X787 w1180 w406 w1181 NAND2
X788 w402 w1176 w1182 NAND2
X789 w1181 w1182 w1183 AND2
X790 w1179 w1183 result NAND2
X791 a b w1184 OR2
X792 a b w1185 AND2
X793 w1185 w398 w1186 ORN2
X794 w395 w1186 w1187 NAND2
X795 w1184 w1187 w1188 NAND2
X796 w402 w1185 w1189 NAND2
X797 w1190 w406 w1191 NAND2
X798 w1189 w1191 w1192 AND2
X799 w1188 w1192 result NAND2
X800 a b w1193 OR2
X801 a b w1194 AND2
X802 w1194 w398 w1195 ORN2
X803 w395 w1195 w1196 NAND2
X804 w1193 w1196 w1197 NAND2
X805 w402 w1194 w1198 NAND2
X806 w1199 w406 w1200 NAND2
X807 w1198 w1200 w1201 AND2
X808 w1197 w1201 result NAND2
X809 a b w1202 OR2
X810 a b w1203 AND2
X811 w1203 w398 w1204 ORN2
X812 w395 w1204 w1205 NAND2
X813 w1202 w1205 w1206 NAND2
X814 w1207 w406 w1208 NAND2
X815 w402 w1203 w1209 NAND2
X816 w1208 w1209 w1210 AND2
X817 w1206 w1210 result NAND2
X818 a b w1211 OR2
X819 a b w1212 AND2
X820 w1212 w398 w1213 ORN2
X821 w395 w1213 w1214 NAND2
X822 w1211 w1214 w1215 NAND2
X823 w1216 w406 w1217 NAND2
X824 w402 w1212 w1218 NAND2
X825 w1217 w1218 w1219 AND2
X826 w1215 w1219 result NAND2
X827 a b w1220 OR2
X828 a b w1221 AND2
X829 w1221 w398 w1222 ORN2
X830 w395 w1222 w1223 NAND2
X831 w1220 w1223 w1224 NAND2
X832 w402 w1221 w1225 NAND2
X833 w1226 w406 w1227 NAND2
X834 w1225 w1227 w1228 AND2
X835 w1224 w1228 result NAND2
X836 a b w1229 OR2
X837 a b w1230 AND2
X838 w1230 w398 w1231 ORN2
X839 w395 w1231 w1232 NAND2
X840 w1229 w1232 w1233 NAND2
X841 w402 w1230 w1234 NAND2
X842 w1235 w406 w1236 NAND2
X843 w1234 w1236 w1237 AND2
X844 w1233 w1237 result NAND2
X845 a b w1238 OR2
X846 a b w1239 AND2
X847 w1239 w398 w1240 ORN2
X848 w395 w1240 w1241 NAND2
X849 w1238 w1241 w1242 NAND2
X850 w402 w1239 w1243 NAND2
X851 w1244 w406 w1245 NAND2
X852 w1243 w1245 w1246 AND2
X853 w1242 w1246 result NAND2
X854 a b w1247 OR2
X855 a b w1248 AND2
X856 w1248 w398 w1249 ORN2
X857 w395 w1249 w1250 NAND2
X858 w1247 w1250 w1251 NAND2
X859 w1252 w406 w1253 NAND2
X860 w402 w1248 w1254 NAND2
X861 w1253 w1254 w1255 AND2
X862 w1251 w1255 result NAND2
X863 a b w1256 OR2
X864 a b w1257 AND2
X865 w1257 w398 w1258 ORN2
X866 w395 w1258 w1259 NAND2
X867 w1256 w1259 w1260 NAND2
X868 w1261 w406 w1262 NAND2
X869 w402 w1257 w1263 NAND2
X870 w1262 w1263 w1264 AND2
X871 w1260 w1264 result NAND2
X872 a b w1265 OR2
X873 a b w1266 AND2
X874 w1266 w398 w1267 ORN2
X875 w395 w1267 w1268 NAND2
X876 w1265 w1268 w1269 NAND2
X877 w1270 w406 w1271 NAND2
X878 w402 w1266 w1272 NAND2
X879 w1271 w1272 w1273 AND2
X880 w1269 w1273 result NAND2
X881 a b w1274 OR2
X882 a b w1275 AND2
X883 w1275 w398 w1276 ORN2
X884 w395 w1276 w1277 NAND2
X885 w1274 w1277 w1278 NAND2
X886 w1279 w406 w1280 NAND2
X887 w402 w1275 w1281 NAND2
X888 w1280 w1281 w1282 AND2
X889 w1278 w1282 result NAND2
X890 a b w1283 OR2
X891 a b w1284 AND2
X892 w1284 w398 w1285 ORN2
X893 w395 w1285 w1286 NAND2
X894 w1283 w1286 w1287 NAND2
X895 w1288 w406 w1289 NAND2
X896 w402 w1284 w1290 NAND2
X897 w1289 w1290 w1291 AND2
X898 w1287 w1291 result NAND2
X899 a b w1292 OR2
X900 a b w1293 AND2
X901 w1293 w398 w1294 ORN2
X902 w395 w1294 w1295 NAND2
X903 w1292 w1295 w1296 NAND2
X904 w1297 w406 w1298 NAND2
X905 w402 w1293 w1299 NAND2
X906 w1298 w1299 w1300 AND2
X907 w1296 w1300 result NAND2
X908 a b w1301 OR2
X909 a b w1302 AND2
X910 w1302 w398 w1303 ORN2
X911 w395 w1303 w1304 NAND2
X912 w1301 w1304 w1305 NAND2
X913 w402 w1302 w1306 NAND2
X914 w1307 w406 w1308 NAND2
X915 w1306 w1308 w1309 AND2
X916 w1305 w1309 result NAND2
X917 a b w1310 OR2
X918 a b w1311 AND2
X919 w1311 w398 w1312 ORN2
X920 w395 w1312 w1313 NAND2
X921 w1310 w1313 w1314 NAND2
X922 w1315 w406 w1316 NAND2
X923 w402 w1311 w1317 NAND2
X924 w1316 w1317 w1318 AND2
X925 w1314 w1318 result NAND2
X926 a b w1319 OR2
X927 a b w1320 AND2
X928 w1320 w398 w1321 ORN2
X929 w395 w1321 w1322 NAND2
X930 w1319 w1322 w1323 NAND2
X931 w1324 w406 w1325 NAND2
X932 w402 w1320 w1326 NAND2
X933 w1325 w1326 w1327 AND2
X934 w1323 w1327 result NAND2
X935 a b w1328 OR2
X936 a b w1329 AND2
X937 w1329 w398 w1330 ORN2
X938 w395 w1330 w1331 NAND2
X939 w1328 w1331 w1332 NAND2
X940 w402 w1329 w1333 NAND2
X941 w1334 w406 w1335 NAND2
X942 w1333 w1335 w1336 AND2
X943 w1332 w1336 result NAND2
X944 a b w1337 OR2
X945 a b w1338 AND2
X946 w1338 w398 w1339 ORN2
X947 w395 w1339 w1340 NAND2
X948 w1337 w1340 w1341 NAND2
X949 w402 w1338 w1342 NAND2
X950 w1343 w406 w1344 NAND2
X951 w1342 w1344 w1345 AND2
X952 w1341 w1345 result NAND2
X953 a b w1346 OR2
X954 a b w1347 AND2
X955 w1347 w398 w1348 ORN2
X956 w395 w1348 w1349 NAND2
X957 w1346 w1349 w1350 NAND2
X958 w1351 w406 w1352 NAND2
X959 w402 w1347 w1353 NAND2
X960 w1352 w1353 w1354 AND2
X961 w1350 w1354 result NAND2
X962 a b w1355 OR2
X963 a b w1356 AND2
X964 w1356 w398 w1357 ORN2
X965 w395 w1357 w1358 NAND2
X966 w1355 w1358 w1359 NAND2
X967 w1360 w406 w1361 NAND2
X968 w402 w1356 w1362 NAND2
X969 w1361 w1362 w1363 AND2
X970 w1359 w1363 result NAND2
X971 a b w1364 OR2
X972 a b w1365 AND2
X973 w1365 w398 w1366 ORN2
X974 w395 w1366 w1367 NAND2
X975 w1364 w1367 w1368 NAND2
X976 w402 w1365 w1369 NAND2
X977 w1370 w406 w1371 NAND2
X978 w1369 w1371 w1372 AND2
X979 w1368 w1372 result NAND2
X980 a b w1373 OR2
X981 a b w1374 AND2
X982 w1374 w398 w1375 ORN2
X983 w395 w1375 w1376 NAND2
X984 w1373 w1376 w1377 NAND2
X985 w402 w1374 w1378 NAND2
X986 w1379 w406 w1380 NAND2
X987 w1378 w1380 w1381 AND2
X988 w1377 w1381 result NAND2
X989 a b w1382 OR2
X990 a b w1383 AND2
X991 w1383 w398 w1384 ORN2
X992 w395 w1384 w1385 NAND2
X993 w1382 w1385 w1386 NAND2
X994 w402 w1383 w1387 NAND2
X995 w1388 w406 w1389 NAND2
X996 w1387 w1389 w1390 AND2
X997 w1386 w1390 result NAND2
X998 a b w1391 OR2
X999 a b w1392 AND2
X1000 w1392 w398 w1393 ORN2
X1001 w395 w1393 w1394 NAND2
X1002 w1391 w1394 w1395 NAND2
X1003 w1396 w406 w1397 NAND2
X1004 w402 w1392 w1398 NAND2
X1005 w1397 w1398 w1399 AND2
X1006 w1395 w1399 result NAND2
X1007 a b w1400 OR2
X1008 a b w1401 AND2
X1009 w1401 w398 w1402 ORN2
X1010 w395 w1402 w1403 NAND2
X1011 w1400 w1403 w1404 NAND2
X1012 w1405 w406 w1406 NAND2
X1013 w402 w1401 w1407 NAND2
X1014 w1406 w1407 w1408 AND2
X1015 w1404 w1408 result NAND2
X1016 a b w1409 OR2
X1017 a b w1410 AND2
X1018 w1410 w398 w1411 ORN2
X1019 w395 w1411 w1412 NAND2
X1020 w1409 w1412 w1413 NAND2
X1021 w402 w1410 w1414 NAND2
X1022 w1415 w406 w1416 NAND2
X1023 w1414 w1416 w1417 AND2
X1024 w1413 w1417 result NAND2
X1025 a b w1418 OR2
X1026 a b w1419 AND2
X1027 w1419 w398 w1420 ORN2
X1028 w395 w1420 w1421 NAND2
X1029 w1418 w1421 w1422 NAND2
X1030 w1423 w406 w1424 NAND2
X1031 w402 w1419 w1425 NAND2
X1032 w1424 w1425 w1426 AND2
X1033 w1422 w1426 result NAND2
X1034 a b w1427 OR2
X1035 a b w1428 AND2
X1036 w1428 w398 w1429 ORN2
X1037 w395 w1429 w1430 NAND2
X1038 w1427 w1430 w1431 NAND2
X1039 w1432 w406 w1433 NAND2
X1040 w402 w1428 w1434 NAND2
X1041 w1433 w1434 w1435 AND2
X1042 w1431 w1435 result NAND2
X1043 a b w1436 OR2
X1044 a b w1437 AND2
X1045 w1437 w398 w1438 ORN2
X1046 w395 w1438 w1439 NAND2
X1047 w1436 w1439 w1440 NAND2
X1048 w1441 w406 w1442 NAND2
X1049 w402 w1437 w1443 NAND2
X1050 w1442 w1443 w1444 AND2
X1051 w1440 w1444 result NAND2
X1052 a b w1445 OR2
X1053 a b w1446 AND2
X1054 w1446 w398 w1447 ORN2
X1055 w395 w1447 w1448 NAND2
X1056 w1445 w1448 w1449 NAND2
X1057 w402 w1446 w1450 NAND2
X1058 w1451 w406 w1452 NAND2
X1059 w1450 w1452 w1453 AND2
X1060 w1449 w1453 result NAND2
X1061 a b w1454 OR2
X1062 a b w1455 AND2
X1063 w1455 w398 w1456 ORN2
X1064 w395 w1456 w1457 NAND2
X1065 w1454 w1457 w1458 NAND2
X1066 w1459 w406 w1460 NAND2
X1067 w402 w1455 w1461 NAND2
X1068 w1460 w1461 w1462 AND2
X1069 w1458 w1462 result NAND2
X1070 a b w1463 OR2
X1071 a b w1464 AND2
X1072 w1464 w398 w1465 ORN2
X1073 w395 w1465 w1466 NAND2
X1074 w1463 w1466 w1467 NAND2
X1075 w1468 w406 w1469 NAND2
X1076 w402 w1464 w1470 NAND2
X1077 w1469 w1470 w1471 AND2
X1078 w1467 w1471 result NAND2
X1079 a b w1472 OR2
X1080 a b w1473 AND2
X1081 w1473 w398 w1474 ORN2
X1082 w395 w1474 w1475 NAND2
X1083 w1472 w1475 w1476 NAND2
X1084 w402 w1473 w1477 NAND2
X1085 w1478 w406 w1479 NAND2
X1086 w1477 w1479 w1480 AND2
X1087 w1476 w1480 result NAND2
X1088 a b w1481 OR2
X1089 a b w1482 AND2
X1090 w1482 w398 w1483 ORN2
X1091 w395 w1483 w1484 NAND2
X1092 w1481 w1484 w1485 NAND2
X1093 w402 w1482 w1486 NAND2
X1094 w1487 w406 w1488 NAND2
X1095 w1486 w1488 w1489 AND2
X1096 w1485 w1489 result NAND2
X1097 a b w1490 OR2
X1098 a b w1491 AND2
X1099 w1491 w398 w1492 ORN2
X1100 w395 w1492 w1493 NAND2
X1101 w1490 w1493 w1494 NAND2
X1102 w1495 w406 w1496 NAND2
X1103 w402 w1491 w1497 NAND2
X1104 w1496 w1497 w1498 AND2
X1105 w1494 w1498 result NAND2
X1106 a b w1499 OR2
X1107 a b w1500 AND2
X1108 w1500 w398 w1501 ORN2
X1109 w395 w1501 w1502 NAND2
X1110 w1499 w1502 w1503 NAND2
X1111 w1504 w406 w1505 NAND2
X1112 w402 w1500 w1506 NAND2
X1113 w1505 w1506 w1507 AND2
X1114 w1503 w1507 result NAND2
X1115 a b w1508 OR2
X1116 a b w1509 AND2
X1117 w1509 w398 w1510 ORN2
X1118 w395 w1510 w1511 NAND2
X1119 w1508 w1511 w1512 NAND2
X1120 w402 w1509 w1513 NAND2
X1121 w1514 w406 w1515 NAND2
X1122 w1513 w1515 w1516 AND2
X1123 w1512 w1516 result NAND2
X1124 a b w1517 OR2
X1125 a b w1518 AND2
X1126 w1518 w398 w1519 ORN2
X1127 w395 w1519 w1520 NAND2
X1128 w1517 w1520 w1521 NAND2
X1129 w402 w1518 w1522 NAND2
X1130 w1523 w406 w1524 NAND2
X1131 w1522 w1524 w1525 AND2
X1132 w1521 w1525 result NAND2
X1133 a b w1526 OR2
X1134 a b w1527 AND2
X1135 w1527 w398 w1528 ORN2
X1136 w395 w1528 w1529 NAND2
X1137 w1526 w1529 w1530 NAND2
X1138 w402 w1527 w1531 NAND2
X1139 w1532 w406 w1533 NAND2
X1140 w1531 w1533 w1534 AND2
X1141 w1530 w1534 result NAND2
X1142 a b w1535 OR2
X1143 a b w1536 AND2
X1144 w1536 w398 w1537 ORN2
X1145 w395 w1537 w1538 NAND2
X1146 w1535 w1538 w1539 NAND2
X1147 w1540 w406 w1541 NAND2
X1148 w402 w1536 w1542 NAND2
X1149 w1541 w1542 w1543 AND2
X1150 w1539 w1543 result NAND2
X1151 b w405 w1544 XNOR2
X1152 b w405 w1545 XNOR2
X1153 b w405 w1546 XNOR2
X1154 b w405 w1547 XNOR2
X1155 b w405 w1548 XNOR2
X1156 b w405 w1549 XNOR2
X1157 b w405 w1550 XNOR2
X1158 b w405 w1551 XNOR2
X1159 b w405 w1552 XNOR2
X1160 b w405 w1553 XNOR2
X1161 b w405 w1554 XNOR2
X1162 b w405 w1555 XNOR2
X1163 b w405 w1556 XNOR2
X1164 b w405 w1557 XNOR2
X1165 b w405 w1558 XNOR2
X1166 b w405 w1559 XNOR2
X1167 b w405 w1560 XNOR2
X1168 b w405 w1561 XNOR2
X1169 b w405 w1562 XNOR2
X1170 b w405 w1563 XNOR2
X1171 b w405 w1564 XNOR2
X1172 b w405 w1565 XNOR2
X1173 b w405 w1566 XNOR2
X1174 b w405 w1567 XNOR2
X1175 b w405 w1568 XNOR2
X1176 b w405 w1569 XNOR2
X1177 b w405 w1570 XNOR2
X1178 b w405 w1571 XNOR2
X1179 b w405 w1572 XNOR2
X1180 b w405 w1573 XNOR2
X1181 b w405 w1574 XNOR2
X1182 b w405 w1575 XNOR2
X1183 b w405 w1576 XNOR2
X1184 b w405 w1577 XNOR2
X1185 b w405 w1578 XNOR2
X1186 b w405 w1579 XNOR2
X1187 b w405 w1580 XNOR2
X1188 b w405 w1581 XNOR2
X1189 b w405 w1582 XNOR2
X1190 b w405 w1583 XNOR2
X1191 b w405 w1584 XNOR2
X1192 b w405 w1585 XNOR2
X1193 b w405 w1586 XNOR2
X1194 b w405 w1587 XNOR2
X1195 b w405 w1588 XNOR2
X1196 b w405 w1589 XNOR2
X1197 b w405 w1590 XNOR2
X1198 b w405 w1591 XNOR2
X1199 b w405 w1592 XNOR2
X1200 b w405 w1593 XNOR2
X1201 b w405 w1594 XNOR2
X1202 b w405 w1595 XNOR2
X1203 b w405 w1596 XNOR2
X1204 b w405 w1597 XNOR2
X1205 b w405 w1598 XNOR2
X1206 b w405 w1599 XNOR2
X1207 b w405 w1600 XNOR2
X1208 b w405 w1601 XNOR2
X1209 b w405 w1602 XNOR2
X1210 b w405 w1603 XNOR2
X1211 b w405 w1604 XNOR2
X1212 b w405 w1605 XNOR2
X1213 b w405 w1606 XNOR2
X1214 b w405 w1607 XNOR2
X1215 b w405 w1608 XNOR2
X1216 b w405 w1609 XNOR2
X1217 b w405 w1610 XNOR2
X1218 b w405 w1611 XNOR2
X1219 b w405 w1612 XNOR2
X1220 b w405 w1613 XNOR2
X1221 b w405 w1614 XNOR2
X1222 b w405 w1615 XNOR2
X1223 b w405 w1616 XNOR2
X1224 b w405 w1617 XNOR2
X1225 b w405 w1618 XNOR2
X1226 b w405 w1619 XNOR2
X1227 b w405 w1620 XNOR2
X1228 b w405 w1621 XNOR2
X1229 b w405 w1622 XNOR2
X1230 b w405 w1623 XNOR2
X1231 b w405 w1624 XNOR2
X1232 b w405 w1625 XNOR2
X1233 b w405 w1626 XNOR2
X1234 b w405 w1627 XNOR2
X1235 b w405 w1628 XNOR2
X1236 b w405 w1629 XNOR2
X1237 b w405 w1630 XNOR2
X1238 b w405 w1631 XNOR2
X1239 b w405 w1632 XNOR2
X1240 b w405 w1633 XNOR2
X1241 b w405 w1634 XNOR2
X1242 b w405 w1635 XNOR2
X1243 b w405 w1636 XNOR2
X1244 b w405 w1637 XNOR2
X1245 b w405 w1638 XNOR2
X1246 b w405 w1639 XNOR2
X1247 b w405 w1640 XNOR2
X1248 b w405 w1641 XNOR2
X1249 b w405 w1642 XNOR2
X1250 b w405 w1643 XNOR2
X1251 b w405 w1644 XNOR2
X1252 b w405 w1645 XNOR2
X1253 b w405 w1646 XNOR2
X1254 b w405 w1647 XNOR2
X1255 b w405 w1648 XNOR2
X1256 b w405 w1649 XNOR2
X1257 b w405 w1650 XNOR2
X1258 b w405 w1651 XNOR2
X1259 b w405 w1652 XNOR2
X1260 b w405 w1653 XNOR2
X1261 b w405 w1654 XNOR2
X1262 b w405 w1655 XNOR2
X1263 b w405 w1656 XNOR2
X1264 b w405 w1657 XNOR2
X1265 b w405 w1658 XNOR2
X1266 b w405 w1659 XNOR2
X1267 b w405 w1660 XNOR2
X1268 b w405 w1661 XNOR2
X1269 b w405 w1662 XNOR2
X1270 b w405 w1663 XNOR2
X1271 b w405 w1664 XNOR2
X1272 b w405 w1665 XNOR2
X1273 b w405 w1666 XNOR2
X1274 b w405 w1667 XNOR2
X1275 b w405 w1668 XNOR2
X1276 b w405 w1669 XNOR2
X1277 b w405 w1670 XNOR2
X1278 a b w1671 OR2
X1279 a b w1672 AND2
X1280 w1672 w398 w1673 ORN2
X1281 w395 w1673 w1674 NAND2
X1282 w1671 w1674 w1675 NAND2
X1283 w1676 w406 w1677 NAND2
X1284 w402 w1672 w1678 NAND2
X1285 w1677 w1678 w1679 AND2
X1286 w1675 w1679 result NAND2
X1287 cin w405 w1680 ORN2
X1288 b w405 w1681 XNOR2
X1289 n_0 n_0 n_0 CELL_carry_lo
X1290 n_0 n_0 n_0 CELL_carry_lo
X1291 n_0 n_0 n_0 CELL_carry_lo
X1292 n_0 n_0 n_0 CELL_carry_lo
X1293 n_0 n_0 n_0 CELL_carry_lo
X1294 n_0 n_0 n_0 CELL_carry_lo
X1295 n_0 n_0 n_0 CELL_carry_lo
X1296 n_0 n_0 n_0 CELL_carry_lo
X1297 n_0 n_0 n_0 CELL_carry_lo
X1298 n_0 n_0 n_0 CELL_carry_lo
X1299 n_0 n_0 n_0 CELL_carry_lo
X1300 n_0 n_0 n_0 CELL_carry_lo
X1301 n_0 n_0 n_0 CELL_carry_lo
X1302 n_0 n_0 n_0 CELL_carry_lo
X1303 n_0 n_0 n_0 CELL_carry_lo
X1304 n_0 n_0 n_0 CELL_carry_lo
X1305 n_0 n_0 n_0 CELL_carry_lo
X1306 n_0 n_0 n_0 CELL_carry_lo
X1307 n_0 n_0 n_0 CELL_carry_lo
X1308 n_0 n_0 n_0 CELL_carry_lo
X1309 n_0 n_0 n_0 CELL_carry_lo
X1310 n_0 n_0 n_0 CELL_carry_lo
X1311 n_0 n_0 n_0 CELL_carry_lo
X1312 n_0 n_0 n_0 CELL_carry_lo
X1313 n_0 n_0 n_0 CELL_carry_lo
X1314 n_0 n_0 n_0 CELL_carry_lo
X1315 n_0 n_0 n_0 CELL_carry_lo
X1316 n_0 n_0 n_0 CELL_carry_lo
X1317 n_0 n_0 n_0 CELL_carry_lo
X1318 n_0 n_0 n_0 CELL_carry_lo
X1319 n_0 n_0 n_0 CELL_carry_lo
X1320 n_0 n_0 n_0 CELL_carry_lo

V0 a 0 DC 1.0
V1 b 0 DC 1.0
V2 cin 0 DC 1.0
V3 clk 0 PULSE(0 1.0 1n 0.05n 0.05n 4.95n 10n)
V4 op 0 DC 1.0
V5 reset_n 0 DC 1.0
R_cout cout 0 1Meg
R_result result 0 1Meg

.save all
.options method=gear maxord=2 gmin=1e-12
.options reltol=0.01 vntol=1e-4 abstol=1e-6
.tran 0.05n 50n

.print tran v(cout) v(result)

.end
