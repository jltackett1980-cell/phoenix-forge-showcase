* Phoenix_Hybrid_Ultra SPICE
V1 1 0 DC 3.3
.tran 1n 100n
.end
