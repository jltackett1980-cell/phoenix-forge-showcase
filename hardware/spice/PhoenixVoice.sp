* SPICE Netlist - PhoenixVoice
* Condition: speech_impairment
* Generated by Phoenix Forge

* === POWER TOPOLOGY ===
* Battery: 4003.7V
V_BATT VBAT 0 DC 4003.7
R_BATT_int VBAT 0 0.1

* Charger: MCP73831
V_USB VBUS 0 DC 5.0
D_CHG_REV VBUS VBAT D_SCHOTTKY
R_CHG_PROG PROG 0 2.2k

* Regulator: TPS62740 - VBAT to 3.3V
C_IN_BULK VBAT 0 10u
C_IN_BYP VBAT 0 100n
* Behavioral regulator: VCC = 3.3V
R_REG_load VCC 0 1k
B_REG VCC 0 V=3.3
C_OUT_BULK VCC 0 10u
C_OUT_BYP VCC 0 100n

* === MCU: Nordic nRF52832 ===
* MCU load: 30mA at 3.3V = 110 ohms
R_MCU_load VCC 0 110
C_MCU_BYP1 VCC 0 100n
C_MCU_BYP2 VCC 0 10u

* === SENSORS (2) ===
* S1: FSR 402 - Force sensing resistor — contact detection
R_S1_load VCC 0 3300
C_S1_byp VCC 0 100n
* S2: MAX30102 - PPG — confirm device worn
R_S2_load VCC 0 3300
C_S2_byp VCC 0 100n

* === ACTUATORS (3) ===
* A1: DRV2605L - Haptic driver — ERM/LRA control
R_A1_load VCC 0 66
* A2: Precision Microdrives 310-101 - LRA vibration motor 175Hz resonance
R_A2_load VCC 0 66
* A3: ICM-42688-P - IMU — motion tracking + tremor measurement
R_A3_load VCC 0 66

* === SIMULATION ===
.model D_SCHOTTKY D(Is=1e-7 Rs=0.1 N=1.05)
.options TEMP=25
.control
  op
  print v(VCC) v(VBAT) v(VBUS)
  print i(V_BATT)
.endc
.END
