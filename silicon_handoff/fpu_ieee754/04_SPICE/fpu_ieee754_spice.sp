* SPICE Netlist - Fpu Ieee754
* Generated: 2026-05-15 | Family: General Purpose
.TITLE fpu_ieee754_Circuit
VDD VDD 0 DC 1.11V
R1 VDD N001 34k
C1 N001 0 85.46pF
.OP
.END
