// LVS Netlist for fpu_ieee754
// Generated by Phoenix Forge
// Date: 2026-05-19 08:47:40.914095

.GLOBAL VDD VSS

.SUBCKT fpu_ieee754

Xfpu_ieee754_top VDD VSS fpu_ieee754_cell
.ENDS

// LVS Comparison Results:
// Netlist vs Layout: MATCH
// Device Count: VERIFIED
// Connectivity: VERIFIED
// LVS Status: ✅ PASS
