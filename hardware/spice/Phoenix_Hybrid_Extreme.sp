* Phoenix_Hybrid_Extreme SPICE
V1 1 0 DC 3.3
.tran 1n 100n
.end
