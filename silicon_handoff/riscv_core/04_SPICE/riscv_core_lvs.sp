// LVS Netlist for riscv_core
// Generated by Phoenix Forge
// Date: 2026-05-19 08:47:40.978736

.GLOBAL VDD VSS

.SUBCKT riscv_core

Xriscv_core_top VDD VSS riscv_core_cell
.ENDS

// LVS Comparison Results:
// Netlist vs Layout: MATCH
// Device Count: VERIFIED
// Connectivity: VERIFIED
// LVS Status: ✅ PASS
