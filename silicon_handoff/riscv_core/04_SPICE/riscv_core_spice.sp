* SPICE Netlist - Riscv Core
* Generated: 2026-05-15 | Family: CPU
.TITLE riscv_core_Circuit
VDD VDD 0 DC 2.79V
R1 VDD N001 100k
C1 N001 0 89.49pF
.OP
.END
