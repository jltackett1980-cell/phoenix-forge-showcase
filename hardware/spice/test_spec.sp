* SPICE Netlist — test_spec
* Condition: unknown
* Generated by Phoenix Forge — Book of Life Trust
* Patent Pending 64/045,401
*
* This netlist represents the power topology and sensor interfaces
* for simulation in ngspice. Active components use behavioral models
* based on datasheet specifications.

* ─── POWER TOPOLOGY ───
* Battery: BATT — 3.7V 400mAh
V_BATT	VBAT 0 DC 3.7
R_BATT_int	VBAT 0 0.1

* Charger IC: MCP73831
* Connected between USB_VBUS and VBAT
V_USB	VBUS 0 DC 5.0D_CHG_REV	VBUS VBAT D_SCHOTTKYR_CHG_PROG	PROG 0 2.2k
* Regulator:  — VBAT to 3.3V
C_IN_BULK	VBAT 0 10uFC_IN_BYP	VBAT 0 100nF* Voltage Regulator: REG
* Vin=VBAT, Vout=3.3V, efficiency=0.9
R_REG_load	VCC 0 1k
B_REG	VCC 0 V={ 3.3 }
C_OUT_BULK	VCC 0 10uFC_OUT_BYP	VCC 0 100nF
* ─── SENSORS (3) ───
* ECG —
* Sensor Load: ECG — 2mA
R_ECG_load	VCC 0 1650C_C_ECG_byp	VCC 0 100nF* heart rate —
* Sensor Load: heart_rate — 2mA
R_heart_rate_load	VCC 0 1650C_C_heart_rate_byp	VCC 0 100nF* gyroscope —
* Sensor Load: gyroscope — 2mA
R_gyroscope_load	VCC 0 1650C_C_gyroscope_byp	VCC 0 100nF
* ─── SIMULATION ───
.model D_SCHOTTKY D(Is=1e-7 Rs=0.1 N=1.05)
.options TEMP=25
.control
  op
  print v(VCC) v(VBAT) v(VBUS)
  print i(V_BATT) i(V_REG)
.endc
.END
