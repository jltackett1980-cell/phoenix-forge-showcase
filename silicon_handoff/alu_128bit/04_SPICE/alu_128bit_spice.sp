* SPICE Netlist - Alu 128Bit
* Generated: 2026-05-15 | Family: ALU
.TITLE alu_128bit_Circuit
VDD VDD 0 DC 1.96V
R1 VDD N001 86k
C1 N001 0 86.32pF
.OP
.END
