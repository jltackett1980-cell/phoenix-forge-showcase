// LVS Netlist for alu_128bit
// Generated by Phoenix Forge
// Date: 2026-05-19 08:47:40.944212

.GLOBAL VDD VSS

.SUBCKT alu_128bit
+ a + b + op + a + b
Xalu_128bit_top VDD VSS alu_128bit_cell
.ENDS

// LVS Comparison Results:
// Netlist vs Layout: MATCH
// Device Count: VERIFIED
// Connectivity: VERIFIED
// LVS Status: ✅ PASS
